;; Native Virtuoso Wire-Label Stub Extension for cell "opamp_core_p07_signed_bridge_drives_gn"
;; Generated by analog-schem-gen (gridUnit = 0.0625)
procedure(asgApplyWireLabelStubs(cv)
  let((w figs midX midY)
    figs = schCreateWire(cv "draw" "full" list(9.25:4.0 9.25:3.75) 0.0625 0.0625 0.0)
    when(figs schCreateWireLabel(cv car(figs) 9.25:3.875 "ep" "lowerCenter" "R90" "stick" 0.05 nil))
    figs = schCreateWire(cv "draw" "full" list(10.1875:4.0 10.1875:3.75) 0.0625 0.0625 0.0)
    when(figs schCreateWireLabel(cv car(figs) 10.1875:3.875 "ep" "lowerCenter" "R90" "stick" 0.05 nil))
    figs = schCreateWire(cv "draw" "full" list(13.0:4.0 13.0:3.75) 0.0625 0.0625 0.0)
    when(figs schCreateWireLabel(cv car(figs) 13.0:3.875 "ep" "lowerCenter" "R90" "stick" 0.05 nil))
    figs = schCreateWire(cv "draw" "full" list(13.9375:4.0 13.9375:3.75) 0.0625 0.0625 0.0)
    when(figs schCreateWireLabel(cv car(figs) 13.9375:3.875 "ep" "lowerCenter" "R90" "stick" 0.05 nil))
    figs = schCreateWire(cv "draw" "full" list(3.3125:3.0625 3.0625:3.0625) 0.0625 0.0625 0.0)
    when(figs schCreateWireLabel(cv car(figs) 3.1875:3.0625 "ep" "lowerCenter" "R0" "stick" 0.05 nil))
    figs = schCreateWire(cv "draw" "full" list(11.125:4.0 11.125:3.75) 0.0625 0.0625 0.0)
    when(figs schCreateWireLabel(cv car(figs) 11.125:3.875 "en" "lowerCenter" "R90" "stick" 0.05 nil))
    figs = schCreateWire(cv "draw" "full" list(12.0625:4.0 12.0625:3.75) 0.0625 0.0625 0.0)
    when(figs schCreateWireLabel(cv car(figs) 12.0625:3.875 "en" "lowerCenter" "R90" "stick" 0.05 nil))
    figs = schCreateWire(cv "draw" "full" list(14.875:4.0 14.875:3.75) 0.0625 0.0625 0.0)
    when(figs schCreateWireLabel(cv car(figs) 14.875:3.875 "en" "lowerCenter" "R90" "stick" 0.05 nil))
    figs = schCreateWire(cv "draw" "full" list(15.8125:4.0 15.8125:3.75) 0.0625 0.0625 0.0)
    when(figs schCreateWireLabel(cv car(figs) 15.8125:3.875 "en" "lowerCenter" "R90" "stick" 0.05 nil))
    figs = schCreateWire(cv "draw" "full" list(5.5625:3.0625 5.3125:3.0625) 0.0625 0.0625 0.0)
    when(figs schCreateWireLabel(cv car(figs) 5.4375:3.0625 "en" "lowerCenter" "R0" "stick" 0.05 nil))
    schCheck(cv)
    dbSave(cv)
    t
  )
)
