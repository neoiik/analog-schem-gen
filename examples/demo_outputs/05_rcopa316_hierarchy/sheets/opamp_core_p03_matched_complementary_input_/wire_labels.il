;; Native Virtuoso Wire-Label Stub Extension for cell "opamp_core_p03_matched_complementary_input_"
;; Generated by analog-schem-gen (gridUnit = 0.0625)
procedure(asgApplyWireLabelStubs(cv)
  let((w figs midX midY)
    figs = schCreateWire(cv "draw" "full" list(13.125:2.25 13.125:2.5) 0.0625 0.0625 0.0)
    when(figs schCreateWireLabel(cv car(figs) 13.125:2.375 "ap" "lowerCenter" "R90" "stick" 0.05 nil))
    figs = schCreateWire(cv "draw" "full" list(13.125:5.0 13.125:4.75) 0.0625 0.0625 0.0)
    when(figs schCreateWireLabel(cv car(figs) 13.125:4.875 "ap" "lowerCenter" "R90" "stick" 0.05 nil))
    figs = schCreateWire(cv "draw" "full" list(12.875:5.1875 12.625:5.1875) 0.0625 0.0625 0.0)
    when(figs schCreateWireLabel(cv car(figs) 12.75:5.1875 "ap" "lowerCenter" "R0" "stick" 0.05 nil))
    figs = schCreateWire(cv "draw" "full" list(5.9375:5.1875 5.6875:5.1875) 0.0625 0.0625 0.0)
    when(figs schCreateWireLabel(cv car(figs) 5.8125:5.1875 "ap" "lowerCenter" "R0" "stick" 0.05 nil))
    figs = schCreateWire(cv "draw" "full" list(4.0625:5.1875 4.3125:5.1875) 0.0625 0.0625 0.0)
    when(figs schCreateWireLabel(cv car(figs) 4.1875:5.1875 "ap" "lowerCenter" "R0" "stick" 0.05 nil))
    figs = schCreateWire(cv "draw" "full" list(17.4375:5.0 17.4375:4.75) 0.0625 0.0625 0.0)
    when(figs schCreateWireLabel(cv car(figs) 17.4375:4.875 "ap" "lowerCenter" "R90" "stick" 0.05 nil))
    schCheck(cv)
    dbSave(cv)
    t
  )
)
