;; Native Virtuoso Wire-Label Stub Extension for cell "opamp_core_p02_unit_copies_and_continuous"
;; Generated by analog-schem-gen (gridUnit = 0.0625)
procedure(asgApplyWireLabelStubs(cv)
  let((w figs midX midY)
    figs = schCreateWire(cv "draw" "full" list(4.0:5.3125 4.0:5.0625) 0.0625 0.0625 0.0)
    when(figs schCreateWireLabel(cv car(figs) 4.0:5.1875 "hp" "lowerCenter" "R90" "stick" 0.05 nil))
    figs = schCreateWire(cv "draw" "full" list(5.8125:5.3125 5.8125:5.0625) 0.0625 0.0625 0.0)
    when(figs schCreateWireLabel(cv car(figs) 5.8125:5.1875 "hp" "lowerCenter" "R90" "stick" 0.05 nil))
    figs = schCreateWire(cv "draw" "full" list(17.3125:2.625 17.3125:2.875) 0.0625 0.0625 0.0)
    when(figs schCreateWireLabel(cv car(figs) 17.3125:2.75 "hp" "lowerCenter" "R90" "stick" 0.05 nil))
    figs = schCreateWire(cv "draw" "full" list(17.0625:2.4375 16.8125:2.4375) 0.0625 0.0625 0.0)
    when(figs schCreateWireLabel(cv car(figs) 16.9375:2.4375 "hp" "lowerCenter" "R0" "stick" 0.05 nil))
    figs = schCreateWire(cv "draw" "full" list(9.1875:2.4375 8.9375:2.4375) 0.0625 0.0625 0.0)
    when(figs schCreateWireLabel(cv car(figs) 9.0625:2.4375 "hp" "lowerCenter" "R0" "stick" 0.05 nil))
    schCheck(cv)
    dbSave(cv)
    t
  )
)
