;; Native Virtuoso Wire-Label Stub Extension for cell "opamp_core_p06_resistor_referenced_idle_cur"
;; Generated by analog-schem-gen (gridUnit = 0.0625)
procedure(asgApplyWireLabelStubs(cv)
  let((w figs midX midY)
    figs = schCreateWire(cv "draw" "full" list(6.625:3.625 6.625:3.875) 0.0625 0.0625 0.0)
    when(figs schCreateWireLabel(cv car(figs) 6.625:3.75 "iq_p" "lowerCenter" "R90" "stick" 0.05 nil))
    figs = schCreateWire(cv "draw" "full" list(6.625:5.375 6.625:5.125) 0.0625 0.0625 0.0)
    when(figs schCreateWireLabel(cv car(figs) 6.625:5.25 "iq_p" "lowerCenter" "R90" "stick" 0.05 nil))
    figs = schCreateWire(cv "draw" "full" list(6.375:5.5625 6.125:5.5625) 0.0625 0.0625 0.0)
    when(figs schCreateWireLabel(cv car(figs) 6.25:5.5625 "iq_p" "lowerCenter" "R0" "stick" 0.05 nil))
    figs = schCreateWire(cv "draw" "full" list(8.3125:5.5625 8.0625:5.5625) 0.0625 0.0625 0.0)
    when(figs schCreateWireLabel(cv car(figs) 8.1875:5.5625 "iq_p" "lowerCenter" "R0" "stick" 0.05 nil))
    figs = schCreateWire(cv "draw" "full" list(3.875:5.5625 4.125:5.5625) 0.0625 0.0625 0.0)
    when(figs schCreateWireLabel(cv car(figs) 4.0:5.5625 "iq_p" "lowerCenter" "R0" "stick" 0.05 nil))
    schCheck(cv)
    dbSave(cv)
    t
  )
)
