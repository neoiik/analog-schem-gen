;; Native Virtuoso Wire-Label Stub Extension for cell "opamp_core_p05_rail_fraction_shield_referen"
;; Generated by analog-schem-gen (gridUnit = 0.0625)
procedure(asgApplyWireLabelStubs(cv)
  let((w figs midX midY)
    figs = schCreateWire(cv "draw" "full" list(9.0625:5.75 9.0625:5.5) 0.0625 0.0625 0.0)
    when(figs schCreateWireLabel(cv car(figs) 9.0625:5.625 "vdiv_n" "lowerCenter" "R90" "stick" 0.05 nil))
    figs = schCreateWire(cv "draw" "full" list(20.9375:2.25 20.9375:2.5) 0.0625 0.0625 0.0)
    when(figs schCreateWireLabel(cv car(figs) 20.9375:2.375 "vdiv_n" "lowerCenter" "R90" "stick" 0.05 nil))
    figs = schCreateWire(cv "draw" "full" list(22.125:2.25 22.125:2.5) 0.0625 0.0625 0.0)
    when(figs schCreateWireLabel(cv car(figs) 22.125:2.375 "vdiv_n" "lowerCenter" "R90" "stick" 0.05 nil))
    figs = schCreateWire(cv "draw" "full" list(4.0:3.125 4.0:2.875) 0.0625 0.0625 0.0)
    when(figs schCreateWireLabel(cv car(figs) 4.0:3.0 "vdiv_n" "lowerCenter" "R90" "stick" 0.05 nil))
    figs = schCreateWire(cv "draw" "full" list(4.0:2.25 4.0:2.5) 0.0625 0.0625 0.0)
    when(figs schCreateWireLabel(cv car(figs) 4.0:2.375 "vdiv_n" "lowerCenter" "R90" "stick" 0.05 nil))
    figs = schCreateWire(cv "draw" "full" list(12.375:5.75 12.375:5.5) 0.0625 0.0625 0.0)
    when(figs schCreateWireLabel(cv car(figs) 12.375:5.625 "vdiv_p" "lowerCenter" "R90" "stick" 0.05 nil))
    figs = schCreateWire(cv "draw" "full" list(23.3125:2.25 23.3125:2.5) 0.0625 0.0625 0.0)
    when(figs schCreateWireLabel(cv car(figs) 23.3125:2.375 "vdiv_p" "lowerCenter" "R90" "stick" 0.05 nil))
    figs = schCreateWire(cv "draw" "full" list(13.5625:5.75 13.5625:5.5) 0.0625 0.0625 0.0)
    when(figs schCreateWireLabel(cv car(figs) 13.5625:5.625 "vdiv_p" "lowerCenter" "R90" "stick" 0.05 nil))
    figs = schCreateWire(cv "draw" "full" list(2.75:5.75 2.75:5.5) 0.0625 0.0625 0.0)
    when(figs schCreateWireLabel(cv car(figs) 2.75:5.625 "vdiv_p" "lowerCenter" "R90" "stick" 0.05 nil))
    figs = schCreateWire(cv "draw" "full" list(2.75:4.8125 2.75:5.0625) 0.0625 0.0625 0.0)
    when(figs schCreateWireLabel(cv car(figs) 2.75:4.9375 "vdiv_p" "lowerCenter" "R90" "stick" 0.05 nil))
    schCheck(cv)
    dbSave(cv)
    t
  )
)
