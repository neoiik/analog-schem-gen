;; Native Virtuoso Wire-Label Stub Extension for cell "opamp_core"
;; Generated by analog-schem-gen (gridUnit = 0.0625)
procedure(asgApplyWireLabelStubs(cv)
  let((w figs midX midY)
    figs = schCreateWire(cv "draw" "full" list(2.6875:9.0625 2.9375:9.0625) 0.0625 0.0625 0.0)
    when(figs schCreateWireLabel(cv car(figs) 2.8125:9.0625 "bp" "lowerCenter" "R0" "stick" 0.05 nil))
    figs = schCreateWire(cv "draw" "full" list(6.375:8.1875 6.375:7.9375) 0.0625 0.0625 0.0)
    when(figs schCreateWireLabel(cv car(figs) 6.375:8.0625 "bp" "lowerCenter" "R90" "stick" 0.05 nil))
    figs = schCreateWire(cv "draw" "full" list(12.125:8.3125 12.125:8.0625) 0.0625 0.0625 0.0)
    when(figs schCreateWireLabel(cv car(figs) 12.125:8.1875 "bp" "lowerCenter" "R90" "stick" 0.05 nil))
    figs = schCreateWire(cv "draw" "full" list(2.6875:5.0625 2.6875:4.8125) 0.0625 0.0625 0.0)
    when(figs schCreateWireLabel(cv car(figs) 2.6875:4.9375 "bp" "lowerCenter" "R90" "stick" 0.05 nil))
    figs = schCreateWire(cv "draw" "full" list(3.1875:1.9375 3.1875:1.6875) 0.0625 0.0625 0.0)
    when(figs schCreateWireLabel(cv car(figs) 3.1875:1.8125 "bp" "lowerCenter" "R90" "stick" 0.05 nil))
    figs = schCreateWire(cv "draw" "full" list(7.375:9.4375 7.625:9.4375) 0.0625 0.0625 0.0)
    when(figs schCreateWireLabel(cv car(figs) 7.5:9.4375 "vshd_n" "lowerCenter" "R0" "stick" 0.05 nil))
    figs = schCreateWire(cv "draw" "full" list(12.625:8.3125 12.625:8.0625) 0.0625 0.0625 0.0)
    when(figs schCreateWireLabel(cv car(figs) 12.625:8.1875 "vshd_n" "lowerCenter" "R90" "stick" 0.05 nil))
    figs = schCreateWire(cv "draw" "full" list(3.6875:5.0625 3.6875:4.8125) 0.0625 0.0625 0.0)
    when(figs schCreateWireLabel(cv car(figs) 3.6875:4.9375 "vshd_n" "lowerCenter" "R90" "stick" 0.05 nil))
    figs = schCreateWire(cv "draw" "full" list(6.375:2.0625 6.375:1.8125) 0.0625 0.0625 0.0)
    when(figs schCreateWireLabel(cv car(figs) 6.375:1.9375 "vshd_n" "lowerCenter" "R90" "stick" 0.05 nil))
    figs = schCreateWire(cv "draw" "full" list(6.625:8.1875 6.625:7.9375) 0.0625 0.0625 0.0)
    when(figs schCreateWireLabel(cv car(figs) 6.625:8.0625 "un" "lowerCenter" "R90" "stick" 0.05 nil))
    figs = schCreateWire(cv "draw" "full" list(12.875:9.3125 13.125:9.3125) 0.0625 0.0625 0.0)
    when(figs schCreateWireLabel(cv car(figs) 13.0:9.3125 "un" "lowerCenter" "R0" "stick" 0.05 nil))
    figs = schCreateWire(cv "draw" "full" list(3.4375:5.0625 3.4375:4.8125) 0.0625 0.0625 0.0)
    when(figs schCreateWireLabel(cv car(figs) 3.4375:4.9375 "un" "lowerCenter" "R90" "stick" 0.05 nil))
    figs = schCreateWire(cv "draw" "full" list(6.875:8.1875 6.875:7.9375) 0.0625 0.0625 0.0)
    when(figs schCreateWireLabel(cv car(figs) 6.875:8.0625 "pcas" "lowerCenter" "R90" "stick" 0.05 nil))
    figs = schCreateWire(cv "draw" "full" list(9.8125:8.4375 9.8125:8.1875) 0.0625 0.0625 0.0)
    when(figs schCreateWireLabel(cv car(figs) 9.8125:8.3125 "pcas" "lowerCenter" "R90" "stick" 0.05 nil))
    figs = schCreateWire(cv "draw" "full" list(3.9375:5.3125 4.1875:5.3125) 0.0625 0.0625 0.0)
    when(figs schCreateWireLabel(cv car(figs) 4.0625:5.3125 "pcas" "lowerCenter" "R0" "stick" 0.05 nil))
    figs = schCreateWire(cv "draw" "full" list(7.125:8.1875 7.125:7.9375) 0.0625 0.0625 0.0)
    when(figs schCreateWireLabel(cv car(figs) 7.125:8.0625 "ncas" "lowerCenter" "R90" "stick" 0.05 nil))
    figs = schCreateWire(cv "draw" "full" list(10.0625:8.4375 10.0625:8.1875) 0.0625 0.0625 0.0)
    when(figs schCreateWireLabel(cv car(figs) 10.0625:8.3125 "ncas" "lowerCenter" "R90" "stick" 0.05 nil))
    figs = schCreateWire(cv "draw" "full" list(3.9375:5.5625 4.1875:5.5625) 0.0625 0.0625 0.0)
    when(figs schCreateWireLabel(cv car(figs) 4.0625:5.5625 "ncas" "lowerCenter" "R0" "stick" 0.05 nil))
    figs = schCreateWire(cv "draw" "full" list(7.375:8.4375 7.625:8.4375) 0.0625 0.0625 0.0)
    when(figs schCreateWireLabel(cv car(figs) 7.5:8.4375 "gp" "lowerCenter" "R0" "stick" 0.05 nil))
    figs = schCreateWire(cv "draw" "full" list(12.875:4.9375 12.875:4.6875) 0.0625 0.0625 0.0)
    when(figs schCreateWireLabel(cv car(figs) 12.875:4.8125 "gp" "lowerCenter" "R90" "stick" 0.05 nil))
    figs = schCreateWire(cv "draw" "full" list(3.4375:1.9375 3.4375:1.6875) 0.0625 0.0625 0.0)
    when(figs schCreateWireLabel(cv car(figs) 3.4375:1.8125 "gp" "lowerCenter" "R90" "stick" 0.05 nil))
    figs = schCreateWire(cv "draw" "full" list(6.125:2.0625 6.125:1.8125) 0.0625 0.0625 0.0)
    when(figs schCreateWireLabel(cv car(figs) 6.125:1.9375 "gp" "lowerCenter" "R90" "stick" 0.05 nil))
    figs = schCreateWire(cv "draw" "full" list(12.875:9.0625 13.125:9.0625) 0.0625 0.0625 0.0)
    when(figs schCreateWireLabel(cv car(figs) 13.0:9.0625 "up" "lowerCenter" "R0" "stick" 0.05 nil))
    figs = schCreateWire(cv "draw" "full" list(3.1875:5.0625 3.1875:4.8125) 0.0625 0.0625 0.0)
    when(figs schCreateWireLabel(cv car(figs) 3.1875:4.9375 "up" "lowerCenter" "R90" "stick" 0.05 nil))
    figs = schCreateWire(cv "draw" "full" list(7.375:4.5625 7.375:4.3125) 0.0625 0.0625 0.0)
    when(figs schCreateWireLabel(cv car(figs) 7.375:4.4375 "up" "lowerCenter" "R90" "stick" 0.05 nil))
    figs = schCreateWire(cv "draw" "full" list(12.875:8.8125 13.125:8.8125) 0.0625 0.0625 0.0)
    when(figs schCreateWireLabel(cv car(figs) 13.0:8.8125 "hn" "lowerCenter" "R0" "stick" 0.05 nil))
    figs = schCreateWire(cv "draw" "full" list(6.875:4.5625 6.875:4.3125) 0.0625 0.0625 0.0)
    when(figs schCreateWireLabel(cv car(figs) 6.875:4.4375 "hn" "lowerCenter" "R90" "stick" 0.05 nil))
    figs = schCreateWire(cv "draw" "full" list(9.8125:5.0625 9.8125:4.8125) 0.0625 0.0625 0.0)
    when(figs schCreateWireLabel(cv car(figs) 9.8125:4.9375 "hn" "lowerCenter" "R90" "stick" 0.05 nil))
    figs = schCreateWire(cv "draw" "full" list(12.875:8.5625 13.125:8.5625) 0.0625 0.0625 0.0)
    when(figs schCreateWireLabel(cv car(figs) 13.0:8.5625 "pctl" "lowerCenter" "R0" "stick" 0.05 nil))
    figs = schCreateWire(cv "draw" "full" list(6.625:4.5625 6.625:4.3125) 0.0625 0.0625 0.0)
    when(figs schCreateWireLabel(cv car(figs) 6.625:4.4375 "pctl" "lowerCenter" "R90" "stick" 0.05 nil))
    figs = schCreateWire(cv "draw" "full" list(9.3125:5.0625 9.3125:4.8125) 0.0625 0.0625 0.0)
    when(figs schCreateWireLabel(cv car(figs) 9.3125:4.9375 "pctl" "lowerCenter" "R90" "stick" 0.05 nil))
    figs = schCreateWire(cv "draw" "full" list(13.125:4.9375 13.125:4.6875) 0.0625 0.0625 0.0)
    when(figs schCreateWireLabel(cv car(figs) 13.125:4.8125 "gn" "lowerCenter" "R90" "stick" 0.05 nil))
    figs = schCreateWire(cv "draw" "full" list(3.6875:1.9375 3.6875:1.6875) 0.0625 0.0625 0.0)
    when(figs schCreateWireLabel(cv car(figs) 3.6875:1.8125 "gn" "lowerCenter" "R90" "stick" 0.05 nil))
    figs = schCreateWire(cv "draw" "full" list(5.625:2.0625 5.625:1.8125) 0.0625 0.0625 0.0)
    when(figs schCreateWireLabel(cv car(figs) 5.625:1.9375 "gn" "lowerCenter" "R90" "stick" 0.05 nil))
    schCheck(cv)
    dbSave(cv)
    t
  )
)
