;; Native Virtuoso Wire-Label Stub Extension for cell "opamp_core_p09_pedestal_subtraction_and_two"
;; Generated by analog-schem-gen (gridUnit = 0.0625)
procedure(asgApplyWireLabelStubs(cv)
  let((w figs midX midY)
    figs = schCreateWire(cv "draw" "full" list(8.9375:4.0 8.9375:4.25) 0.0625 0.0625 0.0)
    when(figs schCreateWireLabel(cv car(figs) 8.9375:4.125 "ps" "lowerCenter" "R90" "stick" 0.05 nil))
    figs = schCreateWire(cv "draw" "full" list(8.9375:6.5625 8.9375:6.3125) 0.0625 0.0625 0.0)
    when(figs schCreateWireLabel(cv car(figs) 8.9375:6.4375 "ps" "lowerCenter" "R90" "stick" 0.05 nil))
    figs = schCreateWire(cv "draw" "full" list(21.375:6.5625 21.375:6.3125) 0.0625 0.0625 0.0)
    when(figs schCreateWireLabel(cv car(figs) 21.375:6.4375 "ps" "lowerCenter" "R90" "stick" 0.05 nil))
    figs = schCreateWire(cv "draw" "full" list(21.125:6.75 20.875:6.75) 0.0625 0.0625 0.0)
    when(figs schCreateWireLabel(cv car(figs) 21.0:6.75 "ps" "lowerCenter" "R0" "stick" 0.05 nil))
    figs = schCreateWire(cv "draw" "full" list(10.75:6.75 10.5:6.75) 0.0625 0.0625 0.0)
    when(figs schCreateWireLabel(cv car(figs) 10.625:6.75 "ps" "lowerCenter" "R0" "stick" 0.05 nil))
    figs = schCreateWire(cv "draw" "full" list(13.0:6.75 12.75:6.75) 0.0625 0.0625 0.0)
    when(figs schCreateWireLabel(cv car(figs) 12.875:6.75 "ps" "lowerCenter" "R0" "stick" 0.05 nil))
    figs = schCreateWire(cv "draw" "full" list(15.4375:4.0 15.4375:4.25) 0.0625 0.0625 0.0)
    when(figs schCreateWireLabel(cv car(figs) 15.4375:4.125 "pr" "lowerCenter" "R90" "stick" 0.05 nil))
    figs = schCreateWire(cv "draw" "full" list(15.4375:6.5625 15.4375:6.3125) 0.0625 0.0625 0.0)
    when(figs schCreateWireLabel(cv car(figs) 15.4375:6.4375 "pr" "lowerCenter" "R90" "stick" 0.05 nil))
    figs = schCreateWire(cv "draw" "full" list(23.5625:6.5625 23.5625:6.3125) 0.0625 0.0625 0.0)
    when(figs schCreateWireLabel(cv car(figs) 23.5625:6.4375 "pr" "lowerCenter" "R90" "stick" 0.05 nil))
    figs = schCreateWire(cv "draw" "full" list(23.3125:6.75 23.0625:6.75) 0.0625 0.0625 0.0)
    when(figs schCreateWireLabel(cv car(figs) 23.1875:6.75 "pr" "lowerCenter" "R0" "stick" 0.05 nil))
    figs = schCreateWire(cv "draw" "full" list(17.25:6.75 17.0:6.75) 0.0625 0.0625 0.0)
    when(figs schCreateWireLabel(cv car(figs) 17.125:6.75 "pr" "lowerCenter" "R0" "stick" 0.05 nil))
    figs = schCreateWire(cv "draw" "full" list(17.5:6.5625 17.5:6.3125) 0.0625 0.0625 0.0)
    when(figs schCreateWireLabel(cv car(figs) 17.5:6.4375 "brn" "lowerCenter" "R90" "stick" 0.05 nil))
    figs = schCreateWire(cv "draw" "full" list(17.5:4.0 17.5:4.25) 0.0625 0.0625 0.0)
    when(figs schCreateWireLabel(cv car(figs) 17.5:4.125 "brn" "lowerCenter" "R90" "stick" 0.05 nil))
    figs = schCreateWire(cv "draw" "full" list(17.25:3.8125 17.0:3.8125) 0.0625 0.0625 0.0)
    when(figs schCreateWireLabel(cv car(figs) 17.125:3.8125 "brn" "lowerCenter" "R0" "stick" 0.05 nil))
    figs = schCreateWire(cv "draw" "full" list(10.75:3.8125 10.5:3.8125) 0.0625 0.0625 0.0)
    when(figs schCreateWireLabel(cv car(figs) 10.625:3.8125 "brn" "lowerCenter" "R0" "stick" 0.05 nil))
    figs = schCreateWire(cv "draw" "full" list(13.0:3.8125 12.75:3.8125) 0.0625 0.0625 0.0)
    when(figs schCreateWireLabel(cv car(figs) 12.875:3.8125 "brn" "lowerCenter" "R0" "stick" 0.05 nil))
    figs = schCreateWire(cv "draw" "full" list(19.0:4.0 19.0:4.25) 0.0625 0.0625 0.0)
    when(figs schCreateWireLabel(cv car(figs) 19.0:4.125 "os" "lowerCenter" "R90" "stick" 0.05 nil))
    figs = schCreateWire(cv "draw" "full" list(19.0:6.5625 19.0:6.3125) 0.0625 0.0625 0.0)
    when(figs schCreateWireLabel(cv car(figs) 19.0:6.4375 "os" "lowerCenter" "R90" "stick" 0.05 nil))
    figs = schCreateWire(cv "draw" "full" list(24.375:5.3125 24.375:5.5625) 0.0625 0.0625 0.0)
    when(figs schCreateWireLabel(cv car(figs) 24.375:5.4375 "os" "lowerCenter" "R90" "stick" 0.05 nil))
    figs = schCreateWire(cv "draw" "full" list(3.625:5.125 3.375:5.125) 0.0625 0.0625 0.0)
    when(figs schCreateWireLabel(cv car(figs) 3.5:5.125 "os" "lowerCenter" "R0" "stick" 0.05 nil))
    figs = schCreateWire(cv "draw" "full" list(5.75:5.125 5.5:5.125) 0.0625 0.0625 0.0)
    when(figs schCreateWireLabel(cv car(figs) 5.625:5.125 "os" "lowerCenter" "R0" "stick" 0.05 nil))
    schCheck(cv)
    dbSave(cv)
    t
  )
)
